Circuit Scanner - confirmed circuit
.options numdgt=15 reltol=1e-6 abstol=1e-12 vntol=1e-9
C1 n9 n2 1e-08
C2 n4 n5 1e-07
L1 n8 0 0.01
Q1 n2 n5 n6 CS_Q1
.model CS_Q1 NPN(BF=58 IS=1.63177488658405e-14)
R1 n6 n8 10000
R2 n3 n4 27000
V1 n3 n7 DC 5
.save all @c1[i] @c2[i] @l1[i] @q1[ic]
.op
.control
set filetype=ascii
run
write simulation.raw all
quit
.endc
.end
