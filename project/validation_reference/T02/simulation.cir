Circuit Scanner - confirmed circuit
.options numdgt=15 reltol=1e-6 abstol=1e-12 vntol=1e-9
R1 n2 0 1000
R2 n1 n2 1000
V1 n1 0 DC 5
.save all
.op
.control
set filetype=ascii
run
write simulation.raw all
quit
.endc
.end
