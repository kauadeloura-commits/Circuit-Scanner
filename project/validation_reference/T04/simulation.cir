Circuit Scanner - confirmed circuit
.options numdgt=15 reltol=1e-6 abstol=1e-12 vntol=1e-9
D1 n2 0 CS_DIODE
R1 n1 n2 1000
V1 n1 0 DC 5
.model CS_DIODE D(IS=1e-14 N=1 RS=0.1)
.save all @d1[id]
.op
.control
set filetype=ascii
run
write simulation.raw all
quit
.endc
.end
