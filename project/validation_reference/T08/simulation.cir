Circuit Scanner - confirmed circuit
.options numdgt=15 reltol=1e-6 abstol=1e-12 vntol=1e-9
Q1 n3 n2 n1 CS_Q1
.model CS_Q1 PNP(BF=100 IS=1.63177488658405e-14)
R1 0 n2 1000000
R2 n3 0 1000
V1 n1 0 DC 5
.save all @q1[ic]
.op
.control
set filetype=ascii
run
write simulation.raw all
quit
.endc
.end
