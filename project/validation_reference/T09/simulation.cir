Circuit Scanner - confirmed circuit
.options numdgt=15 reltol=1e-6 abstol=1e-12 vntol=1e-9
M1 n3 n2 0 0 CS_M1 W=1u L=1u
.model CS_M1 NMOS(LEVEL=1 VTO=1 KP=0.02 LAMBDA=0)
CM1GD n2 n3 7e-12
CM1GS n2 0 1.7e-11
R1 n1 n3 1000
V1 n1 0 DC 5
V2 n2 0 DC 3
.save all @m1[id]
.op
.control
set filetype=ascii
run
write simulation.raw all
quit
.endc
.end
