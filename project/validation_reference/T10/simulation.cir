Circuit Scanner - confirmed circuit
.options numdgt=15 reltol=1e-6 abstol=1e-12 vntol=1e-9
R1 n2 0 1000
R2 n1 n2 1000
BE1 oa_E1 0 V=100000*(V(n2,n4)+0)
RE1 oa_E1 op_E1 1000
CE1 op_E1 0 2.27364204416993e-05
E1 n4 0 op_E1 0 1
V1 n1 0 DC 5
.save all
.op
.control
set filetype=ascii
run
write simulation.raw all
quit
.endc
.end
